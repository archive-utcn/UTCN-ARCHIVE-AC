[aimspice]
[description]
623
Stabilizator cu reactie fara amplificator de eroare
D1 1 2 Dioda
D2 3 2 Dioda
D3 0 3 Dioda
D4 0 1 Dioda
.Model Dioda D tt=1e-9

D5 0 4 Zener
.Model Zener D bv=5.6

R1 2 4 220
R2 out 0 100
C 2 0 1m

Q 2 4 out Tranzistor
.Model Tranzistor NPN tr=1e-9 tf=1e-9

Vin 1 3 sin(0 10 50 0 0)

!*Cresterea tensiunii Vout determina scaderea tensiunii Vbe care determina cresterea tensiunii Vce => scaderea tensiunii Vout
!*Scaderea tensiunii Vout determina cresterea tensiunii Vbe care determina scaderea tensiunii Vce => cresterea tensiunii Vout
!*Tensiunea de iesire a stabilizatorului are valoare Vout=Vz-Vbe

[tran]
1e-8
60e-3
X
X
0
[ana]
4 1
0
1 1
1 1 -2 10
5
v(1)
v(2)
v(3)
v(4)
v(out)
[end]
