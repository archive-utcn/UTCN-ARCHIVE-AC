[aimspice]
[description]
215
Circuit RC trece-sus(analizã semnal pulse)
C1 in out 470n
R1 out 0 1k
Vin in 0 pulse(0 5 0 0 0 1e-3 2e-3)
!*Condensatorul se incarca cu pozitiv apoi de descarca.Dupa aceea se incarca cu negativ apoi se descarca.
[dc]
1
Vin
0
5
6e-3
[tran]
1e-11
6e-3
X
X
0
[ana]
4 1
0
1 1
1 1 -6 6
2
v(in)
v(out)
[end]
