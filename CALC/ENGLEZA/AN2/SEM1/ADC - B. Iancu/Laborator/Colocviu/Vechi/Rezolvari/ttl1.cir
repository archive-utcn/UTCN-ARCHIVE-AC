[aimspice]
[description]
379
fig 2.1, 2.5, 2.2
.subckt nand a b vcc out
q11 2 1 a tr
q12 2 1 b tr
q2 3 2 4 tr
q3 5 3 6 tr
q4 out 4 0 tr
d3 6 out di
d1 0 b di
d2 0 a di
r1 vcc 1 4k
r2 vcc 3 1.6k
r3 4 0 1k
r4 vcc 5 130
.ends
.model tr npn tr=5e-9 tf=8e-9
.model di d tt=5e-9
x1 a b vcc out nand
va a 0 dc 5 pulse(0 5 0 1e-10 1e-10 0.2e-6 0.4e-6)
vb b 0 dc 5
vcc vcc 0 5
!vo out 0 0

[dc]
1
va
0
5
0.1
[tran]
1e-10
0.5e-6
X
X
0
[ana]
4 1
0
1 1
1 1 0 6
3
v(a)
v(b)
v(out)
[end]
