[aimspice]
[description]
413
Trigger Schmidt cu porti TTL
.subckt si-nu 1 2 7 10
q11 4 3 1 tr
q12 4 3 2 tr
q2 5 4 6 tr
q3 8 5 9 tr
q4 10 6 0 tr
.model tr npn tr=1e-6 tf=1e-6
d1 0 1 dioda
d2 0 2 dioda
d3 9 10 dioda
.model dioda d tt=1e-6
r1 7 3 4k
r2 7 5 1.6k
r3 6 0 1k
r4 7 8 130
.ends
vcc 15 0 5
x1 p p 15 13 si-nu
x2 13 13 15 e si-nu
r1 i p 220
r2 p e 2.2e3
vi i 0 dc 3.5 pulse(0.2 3.5 1e-4 1e-4 1e-4 0.2e-3 0.6e-3)

[dc]
1
vi
0
3.5
0.01
[tran]
1e-6
0.6e-3
X
X
0
[ana]
4 1
0
1 1
1 1 0 5
3
v(p)
v(e)
v(i)
[end]
